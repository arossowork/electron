Actual YAML passive protection network: independent ngspice cross-check
VDD 3V3_D 0 PWL(0 0 1u 3.3)
VL AMP_L 0 SIN(0 5.65685424949238 20 2)
VR AMP_R 0 SIN(0 5.65685424949238 20 2)
R245 3V3_D VREF_1V65 10000
R246 VREF_1V65 0 10000
R247 AMP_L DC_FILTER_L 100000
R248 VREF_1V65 DC_FILTER_L 100000
R249 AMP_R DC_FILTER_R 100000
R250 VREF_1V65 DC_FILTER_R 100000
R251 VREF_1V65 VTH_LO 6810
R252 VTH_LO 0 100000
R253 VREF_1V65 VTH_HI 2870
R254 VTH_HI 0 100000
R264 DC_FILTER_L SENSE_L 49900
R265 SENSE_L VREF_1V65 10000
R266 DC_FILTER_R SENSE_R 49900
R267 SENSE_R VREF_1V65 10000
C240 VREF_1V65 0 1e-05
C241 DC_FILTER_L 0 3.3e-05
C242 DC_FILTER_R 0 3.3e-05
.options method=gear reltol=1e-7 abstol=1e-12
.tran 0.5m 4 0 0.1m uic
.control
run
set wr_singlescale
set wr_vecnames
wrdata protection-passive.dat v(DC_FILTER_L) v(DC_FILTER_R) v(SENSE_L) v(SENSE_R) v(VREF_1V65) v(VTH_HI) v(VTH_LO)
quit
.endc
.end
